* heater_driver.cir - low-side MOSFET heater switch for the PocketPCR block
*
* Open in LTspice (File > Open, then Run). Results of the .meas lines appear
* under View > SPICE Error Log.
*
* What it checks
*   - drain current and MOSFET dissipation during the PWM on-time
*   - gate rise/fall time driven from a 3.3 V GPIO through its output resistance
*
* The MOSFET is a simple level-1 model tuned to roughly match an AO3400A at
* Vgs = 2.5-3.3 V (Vth ~ 1.0 V, Rds(on) ~ 30-45 mOhm). Replace with the vendor
* model for sign-off numbers.

.title PocketPCR heater low-side driver

* 5 V USB-C rail
VBUS vbus 0 DC 5

* Heater trace (measure your own; 2.5 ohm used in hardware/heater_driver_notes.md)
RHEAT vbus drain 2.5

* MCU GPIO: 3.3 V PWM at ~732 Hz, 50 % duty, ~25 ohm output resistance
VGPIO gpio 0 PULSE(0 3.3 0 5n 5n 683u 1366u)
RGPIO gpio gate_in 25
RGATE gate_in gate 100
RPD gate 0 100k

* Low-side switch
M1 drain gate 0 0 NAO3400 W=1 L=1
.model NAO3400 NMOS (LEVEL=1 VTO=1.0 KP=15 LAMBDA=0.01 CGSO=0 CGDO=0)
CGS gate 0 600p
CGD gate drain 80p

.tran 1u 3m

* Measurements (printed to the log)
.meas tran I_on   AVG I(RHEAT) FROM=0.2m TO=0.6m
.meas tran VDS_on AVG V(drain) FROM=0.2m TO=0.6m
.meas tran P_fet  AVG V(drain)*I(RHEAT) FROM=0.2m TO=0.6m
.meas tran t_rise TRIG V(gate) VAL=0.33 RISE=2 TARG V(gate) VAL=2.97 RISE=2
.meas tran t_fall TRIG V(gate) VAL=2.97 FALL=2 TARG V(gate) VAL=0.33 FALL=2

.end
